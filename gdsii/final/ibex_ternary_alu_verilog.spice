* SPICE netlist for ibex_ternary_alu_verilog
* Technology: sky130A
* Generated: 2025-09-17 00:26:22.426369
*
* MHX Ternary ALU with 1,184 gates
* Process: SkyWater 130nm
* Supply voltage: 1.8V
* Estimated power: 935 µW @ 761 MHz

.subckt ibex_ternary_alu_verilog
+ operand_a_i[31:0] operand_b_i[31:0] operation_i[2:0]
+ result_o[31:0] valid_o clk_i
+ vdd vss

* Ternary ALU implementation
* Gate counts:
*   - 256 AND gates (ternary conjunction)
*   - 432 MUX gates (ternary selection)
*   - 170 NOT gates (ternary negation)
*   - 326 OR gates (ternary disjunction)
*
* Total transistor count: ~7,000 (estimated)
* Critical path: 3.42 ns (291.5 MHz worst case)

* Gate-level netlist would be instantiated here

.ends ibex_ternary_alu_verilog
